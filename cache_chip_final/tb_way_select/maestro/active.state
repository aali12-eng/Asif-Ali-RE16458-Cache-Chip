ADE simulation setup
Test tran: cache_chip_final/tb_way_select/schematic, simulator spectre
  Models: /umbc/software/design_kits/gpdk045_v_6_0/gpdk045/../models/spectre/gpdk045.scs[mc]
  Temperature: 27
  Analysis tran: stop=320n
  Signals: /hit0 as hit0, /hit1 as hit1, /valid0 as valid0, /valid1 as valid1, /lru_way as lru_way, /hit as hit, /miss as miss, /hit_way as hit_way, /victim as victim
Run mode: Single Run, Sweeps and Corners
