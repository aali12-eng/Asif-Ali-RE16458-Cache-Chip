ADE simulation setup
Test tran: cache_chip_final/tb_mux2_n_8/schematic, simulator spectre
  Models: /umbc/software/design_kits/gpdk045_v_6_0/gpdk045/../models/spectre/gpdk045.scs[mc]
  Temperature: 27
  Analysis tran: stop=100n
  Output a = awvCreateBus("a" list(awvAnalog2Digital(VT("/a<7>") nil nil 0.5 nil "centre") awvAnalog2Digital(VT("/a<6>") nil nil 0.5 nil "centre") awvAnalog2Digital(VT("/a<5>") nil nil 0.5 nil "centre") awvAnalog2Digital(VT("/a<4>") nil nil 0.5 nil "centre") awvAnalog2Digital(VT("/a<3>") nil nil 0.5 nil "centre") awvAnalog2Digital(VT("/a<2>") nil nil 0.5 nil "centre") awvAnalog2Digital(VT("/a<1>") nil nil 0.5 nil "centre") awvAnalog2Digital(VT("/a<0>") nil nil 0.5 nil "centre")) "Hex")
  Output b = awvCreateBus("b" list(awvAnalog2Digital(VT("/b<7>") nil nil 0.5 nil "centre") awvAnalog2Digital(VT("/b<6>") nil nil 0.5 nil "centre") awvAnalog2Digital(VT("/b<5>") nil nil 0.5 nil "centre") awvAnalog2Digital(VT("/b<4>") nil nil 0.5 nil "centre") awvAnalog2Digital(VT("/b<3>") nil nil 0.5 nil "centre") awvAnalog2Digital(VT("/b<2>") nil nil 0.5 nil "centre") awvAnalog2Digital(VT("/b<1>") nil nil 0.5 nil "centre") awvAnalog2Digital(VT("/b<0>") nil nil 0.5 nil "centre")) "Hex")
  Output y = awvCreateBus("y" list(awvAnalog2Digital(VT("/y<7>") nil nil 0.5 nil "centre") awvAnalog2Digital(VT("/y<6>") nil nil 0.5 nil "centre") awvAnalog2Digital(VT("/y<5>") nil nil 0.5 nil "centre") awvAnalog2Digital(VT("/y<4>") nil nil 0.5 nil "centre") awvAnalog2Digital(VT("/y<3>") nil nil 0.5 nil "centre") awvAnalog2Digital(VT("/y<2>") nil nil 0.5 nil "centre") awvAnalog2Digital(VT("/y<1>") nil nil 0.5 nil "centre") awvAnalog2Digital(VT("/y<0>") nil nil 0.5 nil "centre")) "Hex")
  Signals: /a<7> as a7, /a<6> as a6, /a<5> as a5, /a<4> as a4, /a<3> as a3, /a<2> as a2, /a<1> as a1, /a<0> as a0, /b<7> as b7, /b<6> as b6, /b<5> as b5, /b<4> as b4, /b<3> as b3, /b<2> as b2, /b<1> as b1, /b<0> as b0, /s as s, /y<7> as y7, /y<6> as y6, /y<5> as y5, /y<4> as y4, /y<3> as y3, /y<2> as y2, /y<1> as y1, /y<0> as y0
Run mode: Single Run, Sweeps and Corners
