ADE simulation setup
Test tran: cache_chip_final/tb_counter/schematic, simulator spectre
  Models: /umbc/software/design_kits/gpdk045_v_6_0/gpdk045/../models/spectre/gpdk045.scs[mc]
  Temperature: 27
  Analysis tran: stop=430n
  Output q = awvCreateBus("q" list(awvAnalog2Digital(VT("/q<4>") nil nil 0.5 nil "centre") awvAnalog2Digital(VT("/q<3>") nil nil 0.5 nil "centre") awvAnalog2Digital(VT("/q<2>") nil nil 0.5 nil "centre") awvAnalog2Digital(VT("/q<1>") nil nil 0.5 nil "centre") awvAnalog2Digital(VT("/q<0>") nil nil 0.5 nil "centre")) "Hex")
  Signals: /count as count, /restart as restart, /clk as clk, /q<4> as q4, /q<3> as q3, /q<2> as q2, /q<1> as q1, /q<0> as q0
Run mode: Single Run, Sweeps and Corners
