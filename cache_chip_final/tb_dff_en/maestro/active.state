ADE simulation setup
Test tran: cache_chip_final/tb_dff_en/schematic, simulator spectre
  Models: /umbc/software/design_kits/gpdk045_v_6_0/gpdk045/../models/spectre/gpdk045.scs[mc]
  Temperature: 27
  Analysis tran: stop=20n
  Signals: /d as d, /load as load, /clk as clk, /q as q
Run mode: Single Run, Sweeps and Corners
