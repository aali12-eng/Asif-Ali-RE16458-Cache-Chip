ADE simulation setup
Test tran: cache_chip_final/tb_mux2_n_2/schematic, simulator spectre
  Models: /umbc/software/design_kits/gpdk045_v_6_0/gpdk045/../models/spectre/gpdk045.scs[mc]
  Temperature: 27
  Analysis tran: stop=64n
  Output a = awvCreateBus("a" list(awvAnalog2Digital(VT("/a<1>") nil nil 0.5 nil "centre") awvAnalog2Digital(VT("/a<0>") nil nil 0.5 nil "centre")) "Hex")
  Output b = awvCreateBus("b" list(awvAnalog2Digital(VT("/b<1>") nil nil 0.5 nil "centre") awvAnalog2Digital(VT("/b<0>") nil nil 0.5 nil "centre")) "Hex")
  Output y = awvCreateBus("y" list(awvAnalog2Digital(VT("/y<1>") nil nil 0.5 nil "centre") awvAnalog2Digital(VT("/y<0>") nil nil 0.5 nil "centre")) "Hex")
  Signals: /a<1> as a1, /a<0> as a0, /b<1> as b1, /b<0> as b0, /s as s, /y<1> as y1, /y<0> as y0
Run mode: Single Run, Sweeps and Corners
