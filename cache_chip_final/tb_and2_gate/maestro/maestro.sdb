ADE simulation setup
Run mode: Single Run, Sweeps and Corners
Tests:
  tran: cache_chip_final/tb_and2_gate/schematic, simulator spectre
