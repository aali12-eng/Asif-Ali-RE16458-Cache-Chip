ADE simulation setup
Test tran: cache_chip_final/tb_Dlatch/schematic, simulator spectre
  Models: /umbc/software/design_kits/gpdk045_v_6_0/gpdk045/../models/spectre/gpdk045.scs[mc]
  Temperature: 27
  Analysis tran: stop=16n
  Signals: /d as d, /clk as clk, /q as q, /qbar as qbar
Run mode: Single Run, Sweeps and Corners
