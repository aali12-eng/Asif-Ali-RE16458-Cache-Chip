ADE simulation setup
Test tran: cache_chip_final/tb_chip_hold/schematic, simulator spectre
  Models: /umbc/software/design_kits/gpdk045_v_6_0/gpdk045/../models/spectre/gpdk045.scs[mc]
  Temperature: 27
  Analysis tran: stop=520n
  Output cpu_add = awvCreateBus("cpu_add" list(awvAnalog2Digital(VT("/cpu_add<5>") nil nil 0.5 nil "centre") awvAnalog2Digital(VT("/cpu_add<4>") nil nil 0.5 nil "centre") awvAnalog2Digital(VT("/cpu_add<3>") nil nil 0.5 nil "centre") awvAnalog2Digital(VT("/cpu_add<2>") nil nil 0.5 nil "centre") awvAnalog2Digital(VT("/cpu_add<1>") nil nil 0.5 nil "centre") awvAnalog2Digital(VT("/cpu_add<0>") nil nil 0.5 nil "centre")) "Hex")
  Output mem_data = awvCreateBus("mem_data" list(awvAnalog2Digital(VT("/mem_data<7>") nil nil 0.5 nil "centre") awvAnalog2Digital(VT("/mem_data<6>") nil nil 0.5 nil "centre") awvAnalog2Digital(VT("/mem_data<5>") nil nil 0.5 nil "centre") awvAnalog2Digital(VT("/mem_data<4>") nil nil 0.5 nil "centre") awvAnalog2Digital(VT("/mem_data<3>") nil nil 0.5 nil "centre") awvAnalog2Digital(VT("/mem_data<2>") nil nil 0.5 nil "centre") awvAnalog2Digital(VT("/mem_data<1>") nil nil 0.5 nil "centre") awvAnalog2Digital(VT("/mem_data<0>") nil nil 0.5 nil "centre")) "Hex")
  Output mem_add = awvCreateBus("mem_add" list(awvAnalog2Digital(VT("/mem_add<5>") nil nil 0.5 nil "centre") awvAnalog2Digital(VT("/mem_add<4>") nil nil 0.5 nil "centre") awvAnalog2Digital(VT("/mem_add<3>") nil nil 0.5 nil "centre") awvAnalog2Digital(VT("/mem_add<2>") nil nil 0.5 nil "centre") awvAnalog2Digital(VT("/mem_add<1>") nil nil 0.5 nil "centre") awvAnalog2Digital(VT("/mem_add<0>") nil nil 0.5 nil "centre")) "Hex")
  Output cpu_data = awvCreateBus("cpu_data" list(awvAnalog2Digital(VT("/cpu_data<7>") nil nil 0.5 nil "centre") awvAnalog2Digital(VT("/cpu_data<6>") nil nil 0.5 nil "centre") awvAnalog2Digital(VT("/cpu_data<5>") nil nil 0.5 nil "centre") awvAnalog2Digital(VT("/cpu_data<4>") nil nil 0.5 nil "centre") awvAnalog2Digital(VT("/cpu_data<3>") nil nil 0.5 nil "centre") awvAnalog2Digital(VT("/cpu_data<2>") nil nil 0.5 nil "centre") awvAnalog2Digital(VT("/cpu_data<1>") nil nil 0.5 nil "centre") awvAnalog2Digital(VT("/cpu_data<0>") nil nil 0.5 nil "centre")) "Hex")
  Signals: /cpu_add<5> as cpu_add5, /cpu_add<4> as cpu_add4, /cpu_add<3> as cpu_add3, /cpu_add<2> as cpu_add2, /cpu_add<1> as cpu_add1, /cpu_add<0> as cpu_add0, /cpu_rd_wrn as cpu_rd_wrn, /start as start, /clk as clk, /reset as reset, /mem_data<7> as mem_data7, /mem_data<6> as mem_data6, /mem_data<5> as mem_data5, /mem_data<4> as mem_data4, /mem_data<3> as mem_data3, /mem_data<2> as mem_data2, /mem_data<1> as mem_data1, /mem_data<0> as mem_data0, /busy as busy, /mem_en as mem_en, /mem_add<5> as mem_add5, /mem_add<4> as mem_add4, /mem_add<3> as mem_add3, /mem_add<2> as mem_add2, /mem_add<1> as mem_add1, /mem_add<0> as mem_add0, /cpu_data<7> as cpu_data7, /cpu_data<6> as cpu_data6, /cpu_data<5> as cpu_data5, /cpu_data<4> as cpu_data4, /cpu_data<3> as cpu_data3, /cpu_data<2> as cpu_data2, /cpu_data<1> as cpu_data1, /cpu_data<0> as cpu_data0
Run mode: Single Run, Sweeps and Corners
