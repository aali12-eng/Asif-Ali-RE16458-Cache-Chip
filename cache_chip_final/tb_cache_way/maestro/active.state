ADE simulation setup
Test tran: cache_chip_final/tb_cache_way/schematic, simulator spectre
  Models: /umbc/software/design_kits/gpdk045_v_6_0/gpdk045/../models/spectre/gpdk045.scs[mc]
  Temperature: 27
  Analysis tran: stop=180n
  Output block_select = awvCreateBus("block_select" list(awvAnalog2Digital(VT("/block_select<3>") nil nil 0.5 nil "centre") awvAnalog2Digital(VT("/block_select<2>") nil nil 0.5 nil "centre") awvAnalog2Digital(VT("/block_select<1>") nil nil 0.5 nil "centre") awvAnalog2Digital(VT("/block_select<0>") nil nil 0.5 nil "centre")) "Hex")
  Output byte_select = awvCreateBus("byte_select" list(awvAnalog2Digital(VT("/byte_select<3>") nil nil 0.5 nil "centre") awvAnalog2Digital(VT("/byte_select<2>") nil nil 0.5 nil "centre") awvAnalog2Digital(VT("/byte_select<1>") nil nil 0.5 nil "centre") awvAnalog2Digital(VT("/byte_select<0>") nil nil 0.5 nil "centre")) "Hex")
  Output write_data = awvCreateBus("write_data" list(awvAnalog2Digital(VT("/write_data<7>") nil nil 0.5 nil "centre") awvAnalog2Digital(VT("/write_data<6>") nil nil 0.5 nil "centre") awvAnalog2Digital(VT("/write_data<5>") nil nil 0.5 nil "centre") awvAnalog2Digital(VT("/write_data<4>") nil nil 0.5 nil "centre") awvAnalog2Digital(VT("/write_data<3>") nil nil 0.5 nil "centre") awvAnalog2Digital(VT("/write_data<2>") nil nil 0.5 nil "centre") awvAnalog2Digital(VT("/write_data<1>") nil nil 0.5 nil "centre") awvAnalog2Digital(VT("/write_data<0>") nil nil 0.5 nil "centre")) "Hex")
  Output tag_in = awvCreateBus("tag_in" list(awvAnalog2Digital(VT("/tag_in<1>") nil nil 0.5 nil "centre") awvAnalog2Digital(VT("/tag_in<0>") nil nil 0.5 nil "centre")) "Hex")
  Output read_data = awvCreateBus("read_data" list(awvAnalog2Digital(VT("/read_data<7>") nil nil 0.5 nil "centre") awvAnalog2Digital(VT("/read_data<6>") nil nil 0.5 nil "centre") awvAnalog2Digital(VT("/read_data<5>") nil nil 0.5 nil "centre") awvAnalog2Digital(VT("/read_data<4>") nil nil 0.5 nil "centre") awvAnalog2Digital(VT("/read_data<3>") nil nil 0.5 nil "centre") awvAnalog2Digital(VT("/read_data<2>") nil nil 0.5 nil "centre") awvAnalog2Digital(VT("/read_data<1>") nil nil 0.5 nil "centre") awvAnalog2Digital(VT("/read_data<0>") nil nil 0.5 nil "centre")) "Hex")
  Output tag_out = awvCreateBus("tag_out" list(awvAnalog2Digital(VT("/tag_out<1>") nil nil 0.5 nil "centre") awvAnalog2Digital(VT("/tag_out<0>") nil nil 0.5 nil "centre")) "Hex")
  Signals: /block_select<3> as block_select3, /block_select<2> as block_select2, /block_select<1> as block_select1, /block_select<0> as block_select0, /byte_select<3> as byte_select3, /byte_select<2> as byte_select2, /byte_select<1> as byte_select1, /byte_select<0> as byte_select0, /write as write, /fill as fill, /reset as reset, /write_data<7> as write_data7, /write_data<6> as write_data6, /write_data<5> as write_data5, /write_data<4> as write_data4, /write_data<3> as write_data3, /write_data<2> as write_data2, /write_data<1> as write_data1, /write_data<0> as write_data0, /tag_in<1> as tag_in1, /tag_in<0> as tag_in0, /read_data<7> as read_data7, /read_data<6> as read_data6, /read_data<5> as read_data5, /read_data<4> as read_data4, /read_data<3> as read_data3, /read_data<2> as read_data2, /read_data<1> as read_data1, /read_data<0> as read_data0, /tag_out<1> as tag_out1, /tag_out<0> as tag_out0, /valid_out as valid_out
Run mode: Single Run, Sweeps and Corners
