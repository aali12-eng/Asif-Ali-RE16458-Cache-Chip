ADE simulation setup
Test tran: cache_chip_final/tb_mux4_n_1/schematic, simulator spectre
  Models: /umbc/software/design_kits/gpdk045_v_6_0/gpdk045/../models/spectre/gpdk045.scs[mc]
  Temperature: 27
  Analysis tran: stop=128n
  Output s = awvCreateBus("s" list(awvAnalog2Digital(VT("/s<1>") nil nil 0.5 nil "centre") awvAnalog2Digital(VT("/s<0>") nil nil 0.5 nil "centre")) "Hex")
  Signals: /d0<0> as d00, /d1<0> as d10, /d2<0> as d20, /d3<0> as d30, /s<1> as s1, /s<0> as s0, /y<0> as y0
Run mode: Single Run, Sweeps and Corners
