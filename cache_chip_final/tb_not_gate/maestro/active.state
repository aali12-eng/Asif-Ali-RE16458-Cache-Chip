ADE simulation setup
Test tran: cache_chip_final/tb_not_gate/schematic, simulator spectre
  Models: /umbc/software/design_kits/gpdk045_v_6_0/gpdk045/../models/spectre/gpdk045.scs[mc]
  Temperature: 27
  Analysis tran: stop=2n
  Signals: /a as a, /y as y
Run mode: Single Run, Sweeps and Corners
