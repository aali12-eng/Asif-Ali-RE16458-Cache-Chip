ADE simulation setup
Test tran: cache_chip_final/tb_hit_miss/schematic, simulator spectre
  Models: /umbc/software/design_kits/gpdk045_v_6_0/gpdk045/../models/spectre/gpdk045.scs[mc]
  Temperature: 27
  Analysis tran: stop=320n
  Output tag = awvCreateBus("tag" list(awvAnalog2Digital(VT("/tag<1>") nil nil 0.5 nil "centre") awvAnalog2Digital(VT("/tag<0>") nil nil 0.5 nil "centre")) "Hex")
  Output stored_tag = awvCreateBus("stored_tag" list(awvAnalog2Digital(VT("/stored_tag<1>") nil nil 0.5 nil "centre") awvAnalog2Digital(VT("/stored_tag<0>") nil nil 0.5 nil "centre")) "Hex")
  Signals: /tag<1> as tag1, /tag<0> as tag0, /stored_tag<1> as stored_tag1, /stored_tag<0> as stored_tag0, /valid as valid, /hit as hit, /miss as miss
Run mode: Single Run, Sweeps and Corners
