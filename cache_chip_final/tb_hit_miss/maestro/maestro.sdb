ADE simulation setup
Run mode: Single Run, Sweeps and Corners
Tests:
  tran: cache_chip_final/tb_hit_miss/schematic, simulator spectre
