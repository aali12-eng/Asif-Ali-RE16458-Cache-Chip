ADE simulation setup
Run mode: Single Run, Sweeps and Corners
Tests:
  tran: cache_chip_final/tb_register_n_8/schematic, simulator spectre
