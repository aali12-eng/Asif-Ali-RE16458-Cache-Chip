ADE simulation setup
Test tran: cache_chip_final/tb_register_n_8/schematic, simulator spectre
  Models: /umbc/software/design_kits/gpdk045_v_6_0/gpdk045/../models/spectre/gpdk045.scs[mc]
  Temperature: 27
  Analysis tran: stop=60n
  Output d = awvCreateBus("d" list(awvAnalog2Digital(VT("/d<7>") nil nil 0.5 nil "centre") awvAnalog2Digital(VT("/d<6>") nil nil 0.5 nil "centre") awvAnalog2Digital(VT("/d<5>") nil nil 0.5 nil "centre") awvAnalog2Digital(VT("/d<4>") nil nil 0.5 nil "centre") awvAnalog2Digital(VT("/d<3>") nil nil 0.5 nil "centre") awvAnalog2Digital(VT("/d<2>") nil nil 0.5 nil "centre") awvAnalog2Digital(VT("/d<1>") nil nil 0.5 nil "centre") awvAnalog2Digital(VT("/d<0>") nil nil 0.5 nil "centre")) "Hex")
  Output q = awvCreateBus("q" list(awvAnalog2Digital(VT("/q<7>") nil nil 0.5 nil "centre") awvAnalog2Digital(VT("/q<6>") nil nil 0.5 nil "centre") awvAnalog2Digital(VT("/q<5>") nil nil 0.5 nil "centre") awvAnalog2Digital(VT("/q<4>") nil nil 0.5 nil "centre") awvAnalog2Digital(VT("/q<3>") nil nil 0.5 nil "centre") awvAnalog2Digital(VT("/q<2>") nil nil 0.5 nil "centre") awvAnalog2Digital(VT("/q<1>") nil nil 0.5 nil "centre") awvAnalog2Digital(VT("/q<0>") nil nil 0.5 nil "centre")) "Hex")
  Signals: /d<7> as d7, /d<6> as d6, /d<5> as d5, /d<4> as d4, /d<3> as d3, /d<2> as d2, /d<1> as d1, /d<0> as d0, /load as load, /clk as clk, /q<7> as q7, /q<6> as q6, /q<5> as q5, /q<4> as q4, /q<3> as q3, /q<2> as q2, /q<1> as q1, /q<0> as q0
Run mode: Single Run, Sweeps and Corners
