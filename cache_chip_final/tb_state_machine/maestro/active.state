ADE simulation setup
Test tran: cache_chip_final/tb_state_machine/schematic, simulator spectre
  Models: /umbc/software/design_kits/gpdk045_v_6_0/gpdk045/../models/spectre/gpdk045.scs[mc]
  Temperature: 27
  Analysis tran: stop=350n
  Output count = awvCreateBus("count" list(awvAnalog2Digital(VT("/count<4>") nil nil 0.5 nil "centre") awvAnalog2Digital(VT("/count<3>") nil nil 0.5 nil "centre") awvAnalog2Digital(VT("/count<2>") nil nil 0.5 nil "centre") awvAnalog2Digital(VT("/count<1>") nil nil 0.5 nil "centre") awvAnalog2Digital(VT("/count<0>") nil nil 0.5 nil "centre")) "Hex")
  Output fill_byte = awvCreateBus("fill_byte" list(awvAnalog2Digital(VT("/fill_byte<1>") nil nil 0.5 nil "centre") awvAnalog2Digital(VT("/fill_byte<0>") nil nil 0.5 nil "centre")) "Hex")
  Output state = awvCreateBus("state" list(awvAnalog2Digital(VT("/state<4>") nil nil 0.5 nil "centre") awvAnalog2Digital(VT("/state<3>") nil nil 0.5 nil "centre") awvAnalog2Digital(VT("/state<2>") nil nil 0.5 nil "centre") awvAnalog2Digital(VT("/state<1>") nil nil 0.5 nil "centre") awvAnalog2Digital(VT("/state<0>") nil nil 0.5 nil "centre")) "Hex")
  Signals: /clk as clk, /reset as reset, /start as start, /read_write as read_write, /hit as hit, /count<4> as count4, /count<3> as count3, /count<2> as count2, /count<1> as count1, /count<0> as count0, /busy as busy, /enable as enable, /output_enable as output_enable, /latch_input as latch_input, /latch_output as latch_output, /count_enable as count_enable, /count_restart as count_restart, /fill_byte<1> as fill_byte1, /fill_byte<0> as fill_byte0, /hit_result as hit_result, /fill as fill, /write as write, /latch_way as latch_way, /lru_update as lru_update, /state<4> as state4, /state<3> as state3, /state<2> as state2, /state<1> as state1, /state<0> as state0
Run mode: Single Run, Sweeps and Corners
