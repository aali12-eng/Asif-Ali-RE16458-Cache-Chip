ADE simulation setup
Test tran: cache_chip_final/tb_decoder2to4/schematic, simulator spectre
  Models: /umbc/software/design_kits/gpdk045_v_6_0/gpdk045/../models/spectre/gpdk045.scs[mc]
  Temperature: 27
  Analysis tran: stop=8n
  Output a = awvCreateBus("a" list(awvAnalog2Digital(VT("/a<1>") nil nil 0.5 nil "centre") awvAnalog2Digital(VT("/a<0>") nil nil 0.5 nil "centre")) "Hex")
  Output y = awvCreateBus("y" list(awvAnalog2Digital(VT("/y<3>") nil nil 0.5 nil "centre") awvAnalog2Digital(VT("/y<2>") nil nil 0.5 nil "centre") awvAnalog2Digital(VT("/y<1>") nil nil 0.5 nil "centre") awvAnalog2Digital(VT("/y<0>") nil nil 0.5 nil "centre")) "Hex")
  Signals: /a<1> as a1, /a<0> as a0, /en as en, /y<3> as y3, /y<2> as y2, /y<1> as y1, /y<0> as y0
Run mode: Single Run, Sweeps and Corners
