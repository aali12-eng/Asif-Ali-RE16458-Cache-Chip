ADE simulation setup
Test tran: cache_chip_final/tb_half_adder/schematic, simulator spectre
  Models: /umbc/software/design_kits/gpdk045_v_6_0/gpdk045/../models/spectre/gpdk045.scs[mc]
  Temperature: 27
  Analysis tran: stop=4n
  Signals: /a as a, /b as b, /sum as sum, /carry as carry
Run mode: Single Run, Sweeps and Corners
