ADE simulation setup
Test tran: cache_chip_final/tb_and_reduce_n/schematic, simulator spectre
  Models: /umbc/software/design_kits/gpdk045_v_6_0/gpdk045/../models/spectre/gpdk045.scs[mc]
  Temperature: 27
  Analysis tran: stop=16n
  Output a = awvCreateBus("a" list(awvAnalog2Digital(VT("/a<3>") nil nil 0.5 nil "centre") awvAnalog2Digital(VT("/a<2>") nil nil 0.5 nil "centre") awvAnalog2Digital(VT("/a<1>") nil nil 0.5 nil "centre") awvAnalog2Digital(VT("/a<0>") nil nil 0.5 nil "centre")) "Hex")
  Signals: /a<3> as a3, /a<2> as a2, /a<1> as a1, /a<0> as a0, /y as y
Run mode: Single Run, Sweeps and Corners
