ADE simulation setup
Test tran: cache_chip_final/tb_selector/schematic, simulator spectre
  Models: /umbc/software/design_kits/gpdk045_v_6_0/gpdk045/../models/spectre/gpdk045.scs[mc]
  Temperature: 27
  Analysis tran: stop=4n
  Signals: /chip_enable as chip_enable, /rd_wrn as rd_wrn, /read_enable as read_enable, /write_enable as write_enable
Run mode: Single Run, Sweeps and Corners
