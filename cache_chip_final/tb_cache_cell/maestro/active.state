ADE simulation setup
Test tran: cache_chip_final/tb_cache_cell/schematic, simulator spectre
  Models: /umbc/software/design_kits/gpdk045_v_6_0/gpdk045/../models/spectre/gpdk045.scs[mc]
  Temperature: 27
  Analysis tran: stop=90n
  Signals: /write_data as write_data, /chip_enable as chip_enable, /rd_wrn as rd_wrn, /read_data as read_data
Run mode: Single Run, Sweeps and Corners
