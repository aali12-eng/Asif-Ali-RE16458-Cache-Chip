ADE simulation setup
Test tran: cache_chip_final/tb_lru/schematic, simulator spectre
  Models: /umbc/software/design_kits/gpdk045_v_6_0/gpdk045/../models/spectre/gpdk045.scs[mc]
  Temperature: 27
  Analysis tran: stop=90n
  Output block_offset = awvCreateBus("block_offset" list(awvAnalog2Digital(VT("/block_offset<1>") nil nil 0.5 nil "centre") awvAnalog2Digital(VT("/block_offset<0>") nil nil 0.5 nil "centre")) "Hex")
  Signals: /clk as clk, /reset as reset, /block_offset<1> as block_offset1, /block_offset<0> as block_offset0, /update as update, /used_way as used_way, /lru_way as lru_way
Run mode: Single Run, Sweeps and Corners
