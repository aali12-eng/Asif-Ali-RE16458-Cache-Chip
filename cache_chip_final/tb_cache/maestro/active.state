ADE simulation setup
Test tran: cache_chip_final/tb_cache/schematic, simulator spectre
  Models: /umbc/software/design_kits/gpdk045_v_6_0/gpdk045/../models/spectre/gpdk045.scs[mc]
  Temperature: 27
  Analysis tran: stop=450n
  Output address = awvCreateBus("address" list(awvAnalog2Digital(VT("/address<5>") nil nil 0.5 nil "centre") awvAnalog2Digital(VT("/address<4>") nil nil 0.5 nil "centre") awvAnalog2Digital(VT("/address<3>") nil nil 0.5 nil "centre") awvAnalog2Digital(VT("/address<2>") nil nil 0.5 nil "centre") awvAnalog2Digital(VT("/address<1>") nil nil 0.5 nil "centre") awvAnalog2Digital(VT("/address<0>") nil nil 0.5 nil "centre")) "Hex")
  Output fill_byte = awvCreateBus("fill_byte" list(awvAnalog2Digital(VT("/fill_byte<1>") nil nil 0.5 nil "centre") awvAnalog2Digital(VT("/fill_byte<0>") nil nil 0.5 nil "centre")) "Hex")
  Output write_data = awvCreateBus("write_data" list(awvAnalog2Digital(VT("/write_data<7>") nil nil 0.5 nil "centre") awvAnalog2Digital(VT("/write_data<6>") nil nil 0.5 nil "centre") awvAnalog2Digital(VT("/write_data<5>") nil nil 0.5 nil "centre") awvAnalog2Digital(VT("/write_data<4>") nil nil 0.5 nil "centre") awvAnalog2Digital(VT("/write_data<3>") nil nil 0.5 nil "centre") awvAnalog2Digital(VT("/write_data<2>") nil nil 0.5 nil "centre") awvAnalog2Digital(VT("/write_data<1>") nil nil 0.5 nil "centre") awvAnalog2Digital(VT("/write_data<0>") nil nil 0.5 nil "centre")) "Hex")
  Output read_data = awvCreateBus("read_data" list(awvAnalog2Digital(VT("/read_data<7>") nil nil 0.5 nil "centre") awvAnalog2Digital(VT("/read_data<6>") nil nil 0.5 nil "centre") awvAnalog2Digital(VT("/read_data<5>") nil nil 0.5 nil "centre") awvAnalog2Digital(VT("/read_data<4>") nil nil 0.5 nil "centre") awvAnalog2Digital(VT("/read_data<3>") nil nil 0.5 nil "centre") awvAnalog2Digital(VT("/read_data<2>") nil nil 0.5 nil "centre") awvAnalog2Digital(VT("/read_data<1>") nil nil 0.5 nil "centre") awvAnalog2Digital(VT("/read_data<0>") nil nil 0.5 nil "centre")) "Hex")
  Signals: /clk as clk, /address<5> as address5, /address<4> as address4, /address<3> as address3, /address<2> as address2, /address<1> as address1, /address<0> as address0, /fill as fill, /fill_byte<1> as fill_byte1, /fill_byte<0> as fill_byte0, /write as write, /latch_way as latch_way, /lru_update as lru_update, /reset as reset, /write_data<7> as write_data7, /write_data<6> as write_data6, /write_data<5> as write_data5, /write_data<4> as write_data4, /write_data<3> as write_data3, /write_data<2> as write_data2, /write_data<1> as write_data1, /write_data<0> as write_data0, /read_data<7> as read_data7, /read_data<6> as read_data6, /read_data<5> as read_data5, /read_data<4> as read_data4, /read_data<3> as read_data3, /read_data<2> as read_data2, /read_data<1> as read_data1, /read_data<0> as read_data0, /hit as hit, /miss as miss, /way as way
Run mode: Single Run, Sweeps and Corners
