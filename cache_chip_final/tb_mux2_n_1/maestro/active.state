ADE simulation setup
Test tran: cache_chip_final/tb_mux2_n_1/schematic, simulator spectre
  Models: /umbc/software/design_kits/gpdk045_v_6_0/gpdk045/../models/spectre/gpdk045.scs[mc]
  Temperature: 27
  Analysis tran: stop=16n
  Signals: /a<0> as a0, /b<0> as b0, /s as s, /y<0> as y0
Run mode: Single Run, Sweeps and Corners
