ADE simulation setup
Run mode: Single Run, Sweeps and Corners
Tests:
  tran: cache_chip_final/tb_mux2_n_1/schematic, simulator spectre
