ADE simulation setup
Test tran: cache_chip_final/tb_or4_gate/schematic, simulator spectre
  Models: /umbc/software/design_kits/gpdk045_v_6_0/gpdk045/../models/spectre/gpdk045.scs[mc]
  Temperature: 27
  Analysis tran: stop=16n
  Signals: /a as a, /b as b, /c as c, /d as d, /y as y
Run mode: Single Run, Sweeps and Corners
